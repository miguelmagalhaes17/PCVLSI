// Design: tutorialCMOS/nand2_test
simulator lang=spectre
global 0 vdd!
include "/home/cadmgr/libs/gpdk045/v6.0/gpdk045/../models/spectre/gpdk045.scs" section=mc

// tutorialCMOS/nand2/schematic
subckt nand2 A B Y
    NM0 (Y A net1 0) g45n1svt w=(120n) l=45n nf=1 m=(1)
    NM1 (net1 B 0 0) g45n1svt w=(120n) l=45n nf=1 m=(1)
    PM1 (Y B vdd! vdd!) g45p1svt w=(120n) l=45n nf=1 m=(1)
    PM0 (Y A vdd! vdd!) g45p1svt w=(120n) l=45n nf=1 m=(1)
ends nand2

// tutorialCMOS/nand2_test/schematic
I0 (InA InB out) nand2
V0 (vdd! 0) vsource dc=1 type=dc
V2 (InB 0) vsource type=pulse val0=0 val1=1 period=20n delay=5n rise=1n fall=1n width=10n
V1 (InA 0) vsource type=pulse val0=0 val1=1 period=20n delay=0 rise=1n fall=1n width=10n
C0 (out 0) capacitor c=1f
simulatorOptions options temp=27
tran tran stop=50n
save InA InB out
