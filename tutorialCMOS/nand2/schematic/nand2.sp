// Design: tutorialCMOS/nand2
simulator lang=spectre
global 0 vdd!
include "/home/cadmgr/libs/gpdk045/v6.0/gpdk045/../models/spectre/gpdk045.scs" section=mc

// tutorialCMOS/nand2/schematic
NM0 (Y A net1 0) g45n1svt w=(120n) l=45n nf=1 m=(1)
NM1 (net1 B 0 0) g45n1svt w=(120n) l=45n nf=1 m=(1)
PM1 (Y B vdd! vdd!) g45p1svt w=(120n) l=45n nf=1 m=(1)
PM0 (Y A vdd! vdd!) g45p1svt w=(120n) l=45n nf=1 m=(1)
simulatorOptions options temp=27
tran tran stop=50n
save Y A B
