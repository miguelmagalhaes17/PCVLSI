// Design: 64comparator/4bitWhiteTest
simulator lang=spectre
global 0 vdd!
include "/home/cadmgr/libs/gpdk045/v6.0/gpdk045/../models/spectre/gpdk045.scs" section=mc

// 64comparator/2bitBlack/schematic
subckt _sub0 Bbig\' EQ\' EQ0 EQ1 G0 G1
    PM4 (EQ\' EQ1 vdd! vdd!) g45p1svt w=(120n) l=45n nf=1 m=(1)
    PM3 (EQ\' EQ0 vdd! vdd!) g45p1svt w=(120n) l=45n nf=1 m=(1)
    PM2 (Bbig\' G1 net1 vdd!) g45p1svt w=(120n) l=45n nf=1 m=(1)
    PM1 (net1 EQ1 vdd! vdd!) g45p1svt w=(120n) l=45n nf=1 m=(1)
    PM0 (net1 G0 vdd! vdd!) g45p1svt w=(120n) l=45n nf=1 m=(1)
    NM4 (EQ\' EQ0 net5 0) g45n1svt w=(120n) l=45n nf=1 m=(1)
    NM3 (net5 EQ1 0 0) g45n1svt w=(120n) l=45n nf=1 m=(1)
    NM2 (net2 G0 0 0) g45n1svt w=(120n) l=45n nf=1 m=(1)
    NM1 (Bbig\' EQ1 net2 0) g45n1svt w=(120n) l=45n nf=1 m=(1)
    NM0 (Bbig\' G1 0 0) g45n1svt w=(120n) l=45n nf=1 m=(1)
ends _sub0

// 64comparator/2bitWhite/schematic
subckt _sub1 Bbig EQ EQ0\' EQ1\' G0\' G1\'
    PM2 (Bbig EQ1\' net2 vdd!) g45p1svt w=(120n) l=45n nf=1 m=(1)
    PM0 (Bbig G1\' vdd! vdd!) g45p1svt w=(120n) l=45n nf=1 m=(1)
    PM1 (net2 G0\' vdd! vdd!) g45p1svt w=(120n) l=45n nf=1 m=(1)
    PM4 (EQ EQ1\' net3 vdd!) g45p1svt w=(120n) l=45n nf=1 m=(1)
    PM3 (net3 EQ0\' vdd! vdd!) g45p1svt w=(120n) l=45n nf=1 m=(1)
    NM0 (net4 G0\' 0 0) g45n1svt w=(120n) l=45n nf=1 m=(1)
    NM2 (net4 EQ1\' 0 0) g45n1svt w=(120n) l=45n nf=1 m=(1)
    NM1 (Bbig G1\' net4 0) g45n1svt w=(120n) l=45n nf=1 m=(1)
    NM4 (EQ EQ0\' 0 0) g45n1svt w=(120n) l=45n nf=1 m=(1)
    NM3 (EQ EQ1\' 0 0) g45n1svt w=(120n) l=45n nf=1 m=(1)
ends _sub1

// 64comparator/2bitEncoding/schematic
subckt _sub2 A B EQ G
    PM3 (EQ B A\' vdd!) g45p1svt w=(120n) l=45n nf=1 m=(1)
    PM2 (B A\' EQ vdd!) g45p1svt w=(120n) l=45n nf=1 m=(1)
    PM1 (A\' A vdd! vdd!) g45p1svt w=(120n) l=45n nf=1 m=(1)
    PM0 (B A G vdd!) g45p1svt w=(120n) l=45n nf=1 m=(1)
    NM4 (EQ B A 0) g45n1svt w=(120n) l=45n nf=1 m=(1)
    NM3 (B A EQ 0) g45n1svt w=(120n) l=45n nf=1 m=(1)
    NM2 (A\' A 0 0) g45n1svt w=(120n) l=45n nf=1 m=(1)
    NM1 (G A 0 0) g45n1svt w=(120n) l=45n nf=1 m=(1)
    NM0 (B A\' G 0) g45n1svt w=(120n) l=45n nf=1 m=(1)
ends _sub2

// 64comparator/4bitWhiteTest/schematic
V6 (inB2 0) vsource type=pulse val0=0 val1=1 period=20n delay=25n rise=1n fall=1n width=10n
V5 (inA2 0) vsource type=pulse val0=0 val1=1 period=20n delay=20n rise=1n fall=1n width=10n
V8 (inB3 0) vsource type=pulse val0=0 val1=1 period=20n delay=35n rise=1n fall=1n width=10n
V7 (inA3 0) vsource type=pulse val0=0 val1=1 period=20n delay=30n rise=1n fall=1n width=10n
V2 (inA1 0) vsource type=pulse val0=0 val1=1 period=20n delay=10n rise=1n fall=1n width=10n
V4 (inB1 0) vsource type=pulse val0=0 val1=1 period=20n delay=15n rise=1n fall=1n width=10n
V1 (inA0 0) vsource type=pulse val0=0 val1=1 period=20n delay=0 rise=1n fall=1n width=10n
V3 (inB0 0) vsource type=pulse val0=0 val1=1 period=20n delay=5n rise=1n fall=1n width=10n
V0 (vdd! 0) vsource dc=1.1 type=dc
I23 (net12 net11 net10 net9 net7 net8) _sub0
I12 (net6 net1 net3 net5 net4 net2) _sub0
I24 (Bbig70 EQ70 net1 net11 net6 net12) _sub1
I13 (inA2 inB2 net10 net7) _sub2
I18 (inA3 inB3 net9 net8) _sub2
I5 (inA1 inB1 net5 net2) _sub2
I0 (inA0 inB0 net3 net4) _sub2
simulatorOptions options temp=27
tran tran stop=5u
save inA0 inB0 inA1 inB1 inB2 inA2 inA3 inB3 EQ70 Bbig70
